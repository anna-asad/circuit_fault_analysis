kvl_series_loop_ABCDEF - fault test
C_FA 0 A 9.27e-06
R_AB A B 5968.352787
R_BC B C 11953.158707
V_CD C D DC 24
R_DE D E 3951.236785
V_EF E 0 DC 6
.op
.control
run
print v(A) v(B) v(C) v(D) v(E)
print @r_ab[i] @r_bc[i] @r_de[i]
.endc
.end
