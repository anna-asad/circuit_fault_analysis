kvl_series_loop_ABCDEF - fault test
R_FA 0 A 373334.566655
R_AB A B 5995.192127
R_BC B C 11836.949911
V_CD C D DC 24
R_DE D E 4061.615194
V_EF E 0 DC 6
.op
.control
run
print v(A) v(B) v(C) v(D) v(E)
print @r_fa[i] @r_ab[i] @r_bc[i] @r_de[i]
.endc
.end
