voltage_divider_12k_9k - fault test
Vs s 0 DC 7.0
C1 s o 6.01e-06
R2 o 0 9110.062679
.op
.control
run
print v(o) v(s)
print @r2[i]
.endc
.end
