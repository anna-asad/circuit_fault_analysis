voltage_divider_12k_9k - fault test
Vs s 0 DC 7.0
R1 s o 11917.940415
R2 o 0 151527.081938
.op
.control
run
print v(o) v(s)
print @r1[i] @r2[i]
.endc
.end
