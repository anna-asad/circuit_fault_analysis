voltage_divider_12k_9k - fault test
Vs s 0 DC 7.0
R1 s o 11860.678167
C2 o 0 1.24e-06
.op
.control
run
print v(o) v(s)
print @r1[i]
.endc
.end
