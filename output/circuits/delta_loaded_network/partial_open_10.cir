delta_loaded_network - fault test
Vin A 0 DC 12
Ra A B 1430.202514
Rb B C 30.285798
Rc C A 29.782524
Rload B 0 30.366431
.op
.control
run
print v(A) v(B) v(C)
print @ra[i] @rb[i] @rc[i] @rload[i]
.endc
.end
