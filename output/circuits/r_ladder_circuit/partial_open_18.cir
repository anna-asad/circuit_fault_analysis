r_ladder_circuit - fault test
Vin in 0 DC 24
R1 in n1 10.067218
R2 n1 0 20.296477
R3 n1 n2 425.182058
R4 n2 0 20.194317
R5 n2 n3 9.949276
R6 n3 0 20.290794
.op
.control
run
print v(in) v(n1) v(n2) v(n3)
print @r1[i] @r2[i] @r3[i] @r4[i] @r5[i] @r6[i]
.endc
.end
