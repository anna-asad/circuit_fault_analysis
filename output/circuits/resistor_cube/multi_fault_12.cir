resistor_cube - fault test
V1 n7 0 DC 12
R1 0 n1 0.993791
R2 0 n2 1.016402
R3 0 n4 0.011885
R4 n1 n3 0.986369
R5 n1 n5 1.006332
R6 n2 n3 1.016572
R7 n2 n6 0.984687
R8 n3 n7 0.981873
R9 n4 n5 1.005298
R10 n4 n6 1.011057
R11 n5 n7 0.999416
R12 n6 n7 31.813421
.op
.control
run
print v(n1) v(n2) v(n3) v(n4) v(n5) v(n6) v(n7)
print @r1[i] @r2[i] @r3[i] @r4[i] @r5[i] @r6[i] @r7[i] @r8[i] @r9[i] @r10[i] @r11[i] @r12[i]
.endc
.end
