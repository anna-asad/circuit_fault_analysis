wheatstone_bridge - fault test
V1 pos 0 DC 20
R1 pos mid1 99.185592
R3 mid1 0 202.528156
R2 pos mid2 149.004821
R4 mid2 0 301.760973
Rg mid1 mid2 1027.865531
.op
.control
run
print v(mid1) v(mid2) v(pos)
print @r1[i] @r3[i] @r2[i] @r4[i] @rg[i]
.endc
.end
