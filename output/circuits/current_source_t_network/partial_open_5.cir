current_source_t_network - fault test
I1 0 a DC 0.005
R_s a b 22160.450652
R_p b 0 986.546983
R_L b c 1518.521479
R_leak c 0 10040607.346119
.op
.control
run
print v(a) v(b) v(c)
print @r_s[i] @r_p[i] @r_l[i] @r_leak[i]
print @i1[i]
.endc
.end
