vdr_parallel_network - fault test
I1 0 T DC 0.012
R1 T 0 267838.614581
R2 T 0 12120.011445
R3 T 0 12001.752052
.op
.control
run
print v(T)
print @r1[i] @r2[i] @r3[i]
print @i1[i]
.endc
.end
