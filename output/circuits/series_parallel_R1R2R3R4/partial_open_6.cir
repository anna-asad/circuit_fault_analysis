series_parallel_R1R2R3R4 - fault test
Vin in 0 DC 10
R1 in a 1012.751744
R2 a b 2017.786016
R3 a b 135674.506226
R4 b 0 1523.941428
.op
.control
run
print v(a) v(b) v(in)
print @r1[i] @r2[i] @r3[i] @r4[i]
.endc
.end
