two_source_bridge - fault test
V1 p1 0 DC 15
V2 p2 0 DC 10
R1 p1 mid1 2480.465956
R3 mid1 0 151.235128
R2 p2 mid2 200.662075
R4 mid2 0 249.661378
R5 mid1 mid2 74.497104
.op
.control
run
print v(mid1) v(mid2) v(p1) v(p2)
print @r1[i] @r3[i] @r2[i] @r4[i] @r5[i]
.endc
.end
