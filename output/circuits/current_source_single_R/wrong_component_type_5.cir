current_source_single_R - fault test
I1 0 p DC 0.012
Cx p 0 6.76e-06
.op
.control
run
print v(p)
print @i1[i]
.endc
.end
