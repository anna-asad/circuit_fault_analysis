current_source_single_R - fault test
I1 0 p DC 0.012
Rx p 0 12545.831479
.op
.control
run
print v(p)
print @rx[i]
print @i1[i]
.endc
.end
