current_source_voltage_divider - fault test
I1 0 out DC 0.01
C1 out 0 2.75e-06
R2 out 0 1971.452142
.op
.control
run
print v(out)
print @r2[i]
print @i1[i]
.endc
.end
