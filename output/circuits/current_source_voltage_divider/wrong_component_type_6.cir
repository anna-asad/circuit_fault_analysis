current_source_voltage_divider - fault test
I1 0 out DC 0.01
R1 out 0 1006.644656
C2 out 0 9.39e-06
.op
.control
run
print v(out)
print @r1[i]
print @i1[i]
.endc
.end
