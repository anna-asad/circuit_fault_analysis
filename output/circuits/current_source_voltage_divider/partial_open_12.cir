current_source_voltage_divider - fault test
I1 0 out DC 0.01
R1 out 0 1010.708282
R2 out 0 76984.232376
.op
.control
run
print v(out)
print @r1[i] @r2[i]
print @i1[i]
.endc
.end
